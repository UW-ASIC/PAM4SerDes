// Standard Verilog-A definitions; disciplines.vams defines electrical nodes.
`include "constants.vams"
`include "disciplines.vams"

// PURPOSE: combine two binary data streams by selecting them alternately.
// This is multiplexing (interleaving): EVEN b0,b2,b4 and ODD b1,b3,b5
// become b0,b1,b2,b3,b4,b5 when the inputs and clock are correctly aligned.
// CML = current-mode logic; hr = half-rate (two output bits per clock cycle).
//
// Default clock convention: positive differential clock selects EVEN;
// negative selects ODD. The selection threshold can be shifted by vos_clk.
// This is a transparent mux: the output follows the selected input, with
// modeled delay. It does not capture/store a bit at a clock edge. Upstream
// circuitry must keep each input stable throughout its selected interval.
//
// In ONE transmitter binary path (MSB or mapped LSB):
//   Before FFE: two cells, clocked at 7 GHz, each combine 2 x 7 -> 14 Gb/s.
//   After FFE: three cells, clocked at 14 GHz, each combine 2 x 14 -> 28 Gb/s.
// The three final cells serialize the PRE, MAIN and POST taps separately.
// The clock frequency is supplied externally, not generated by this module.
// The output remains binary; the later PAM4 driver combines MSB and LSB.
// This is a behavioral equivalent, not the transistor circuit in the paper.
module mux2_cml_hr (
    de_p, de_n, do_p, do_n, clk_p, clk_n, out_p, out_n, vdd, vss
);
    // Each _p/_n pair carries ONE differential signal, not two separate bits.
    // V(p,n) means V(p)-V(n); a positive data difference represents logic 1
    // with the default zero decision offset.
    //   de_p/de_n   : EVEN data input ("de" = data even).
    //   do_p/do_n   : ODD data input  ("do" = data odd).
    //   clk_p/clk_n : differential clock controlling which input is selected.
    //   out_p/out_n : differential output carrying the interleaved bits.
    //   vdd/vss     : supply and reference nodes; voltages come from the
    //                surrounding circuit (the testbench uses 0.7 V / 0 V).
    input de_p, de_n, do_p, do_n, clk_p, clk_n;
    output out_p, out_n;
    inout vdd, vss;
    // "electrical" gives these ports analog voltage/current behavior.
    electrical de_p, de_n, do_p, do_n, clk_p, clk_n;
    electrical out_p, out_n, vdd, vss;

    // Parameters are configurable model settings. Units below are SI.
    // "from (0:inf)" requires a positive value; "from [0:inf)" allows zero.
    // Defaults mix project targets with provisional modeling assumptions;
    // they have not been extracted from a transistor implementation.

    // Total current (A) split between the two output sink branches.
    // 1.5 mA with 200 ohms/leg gives the diagram's 0.6 Vpp differential
    // CML swing when external loading is negligible: Vpp,diff = 2*itail*rload.
    parameter real itail = 1.5e-3 from (0:inf);

    // Internal resistor (ohms) from EACH output to VDD. 200 ohms is an
    // assumed value, separate from the final PAM4 driver's termination.
    parameter real rload = 200.0 from (0:inf);

    // Assumed capacitance (F) from EACH output to VSS. With rload it adds
    // output settling time; default unloaded RC time constant = 1 ps.
    parameter real cout = 5.0e-15 from [0:inf);

    // Data switching softness (V): sets the width of the tanh decision.
    // Smaller values make a sharper decision near vos_data. 10 mV is an
    // assumed smoothing setting, not an input noise specification.
    parameter real vsoft_data = 10.0e-3 from (0:inf);

    // Clock switching softness (V): sets how gradually selection changes
    // between EVEN and ODD near vos_clk; also an assumed 10 mV default.
    parameter real vsoft_clk = 10.0e-3 from (0:inf);

    // Data decision offset (V), applied equally to EVEN and ODD inputs.
    // Zero assumes no offset; a positive value requires more positive
    // differential input voltage to produce a positive logic level.
    parameter real vos_data = 0.0;

    // Clock selection offset (V). At V(clk_p,clk_n) = vos_clk, the mux
    // blends the inputs equally; zero assumes a symmetric clock decision.
    parameter real vos_clk = 0.0;

    // Transport delay (s) applied to the selected signal. 5.934 ps comes
    // from the project notes' timing estimate, not a measured cell delay.
    // The output RC adds delay, so tpd is not the total observed delay.
    parameter real tpd = 5.934e-12 from [0:inf);

    // Requested maximum simulator time step (s). 0.5 ps helps resolve
    // fast transitions; this is a numerical setting, not a hardware delay.
    parameter real max_step = 0.5e-12 from (0:inf);

    // Internal, dimensionless values calculated continuously from inputs:
    //   select_even     : EVEN weight, 0..1; ODD weight is 1-select_even.
    //   even_level      : EVEN data mapped smoothly into -1..+1.
    //   odd_level       : ODD data mapped smoothly into -1..+1.
    //   steering        : selected/blended data level, also -1..+1.
    //   delayed_steering: steering delayed by tpd; controls output currents.
    // -1 represents logic 0 and +1 represents logic 1. These numbers are
    // normalized controls, not output voltages in volts.
    real select_even, even_level, odd_level, steering, delayed_steering;

    analog begin
        // Ask the transient simulator not to step over fast signal changes.
        $bound_step(max_step);

        // 1. Convert the differential clock to a smooth selection weight.
        // tanh approaches +1 for large positive arguments and -1 for large
        // negative arguments; 0.5*(1+tanh(...)) maps this to the range 0..1.
        // Clock well above vos_clk -> select_even near 1 -> select EVEN.
        // Clock well below vos_clk -> select_even near 0 -> select ODD.
        select_even = 0.5 * (1.0 + tanh((V(clk_p, clk_n) - vos_clk)
                                      / vsoft_clk));

        // 2. Convert both differential data inputs to normalized logic.
        // Differences well above/below vos_data approach +1/-1 respectively.
        even_level = tanh((V(de_p, de_n) - vos_data) / vsoft_data);
        odd_level  = tanh((V(do_p, do_n) - vos_data) / vsoft_data);

        // 3. THIS EQUATION PERFORMS THE MULTIPLEXING:
        // select_even = 1 -> steering = even_level.
        // select_even = 0 -> steering = odd_level.
        // Intermediate weights blend the inputs during the clock crossing.
        steering = select_even * even_level + (1.0 - select_even) * odd_level;

        // 4. Model propagation time through the mux. steering is continuous,
        // so absdelay is appropriate; transition is for discrete states.
        delayed_steering = absdelay(steering, tpd);

        // 5. Output load resistors: I=V/R creates a resistor to VDD on each
        // leg. "<+" contributes an analog circuit equation; it is not an
        // ordinary variable assignment. I(a,b) is positive from node a to b.
        I(out_p, vdd) <+ V(out_p, vdd) / rload;
        I(out_n, vdd) <+ V(out_n, vdd) / rload;

        // 6. Split itail between the two branches to create a voltage pair.
        // delayed_steering = +1: P sinks 0, N sinks itail -> out_p > out_n.
        // delayed_steering = -1: P sinks itail, N sinks 0 -> out_p < out_n.
        // These two sink contributions sum to itail; capacitive currents
        // below are additional during transitions.
        // With fully steered current and negligible external loading:
        //   Vdiff = V(out_p,out_n) = +/-itail*rload = +/-0.3 V by default.
        //   Vcm relative to VSS = V(vdd,vss)-itail*rload/2.
        // At a 0.7 V supply: leg levels are 0.7/0.4 V and Vcm is 0.55 V.
        // External loads can change these levels; ideal current sinks here
        // do not model transistor saturation or supply-headroom limits.
        I(out_p, vss) <+ 0.5 * itail * (1.0 - delayed_steering);
        I(out_n, vss) <+ 0.5 * itail * (1.0 + delayed_steering);

        // 7. Output capacitances: I=C*dV/dt. ddt computes the time derivative;
        // these contributions slow voltage changes and draw no DC current.
        I(out_p, vss) <+ cout * ddt(V(out_p, vss));
        I(out_n, vss) <+ cout * ddt(V(out_n, vss));
    end
endmodule
