//! sweep V(inp) = 1.1, 1.3
//! bias V(inn) = 1.2
//! solve

`include "disciplines.vams"

module predriver_cml(inp, inn, outp, outn);

    input inp, inn; //2 diff input from prev stage
    output outp, outn;
    electrical inp, inn, outp, outn;

    // temp output values
    parameter real vcm = 1.2 from (0:inf);
    parameter real vod = 0.2 from (0:inf);

    real bit_sign;

    analog begin
        //determine the input polarity
        bit_sign = (V(inp) > V(inn)) ? 1.0 : -1.0;

        //generate non-inv diff outputs
        V(outp) <+ vcm + (vod / 2.0) * bit_sign;
        V(outn) <+ vcm - (vod / 2.0) * bit_sign;

        $strobe("OUTP = %g V, OUTN = %g V, VDIFF = %g V",
                V(outp), V(outn), V(outp, outn));
    end

endmodule
