//! sweep V(inp) = 1.1, 1.3
//! bias V(inn) = 1.2
//! bias V(ib) = 0.35
//! solve

`include "disciplines.vams"

module predriver_cml(inp, inn, outp, outn, ib, vss);

    input inp, inn; //2 diff input from prev stage
    output outp, outn;
    input ib;       //bias: reference current in, from tx_predrv_bias (one wire per pre-driver)
    inout vss;
    electrical inp, inn, outp, outn, ib, vss;

    // temp output values
    parameter real vcm = 1.2 from (0:inf);
    parameter real vod = 0.2 from (0:inf);

    // bias input: looks like a diode-connected mirror input, vb_nom / ib_nom ohms to vss
    parameter real ib_nom = 100u from (0:inf); //reference current this cell expects
    parameter real vb_nom = 0.35 from (0:inf); //voltage of the bias pin at that current

    real bit_sign;
    real k; //bias current over nominal: the tail current, and so the swing, follows it

    analog begin
        I(ib, vss) <+ V(ib, vss) * ib_nom / vb_nom;
        k = V(ib, vss) / vb_nom;

        // bias check: within 10 % of nominal
        @(above(abs(k - 1.0) - 0.1))
            $strobe("predriver_cml: FAULT, bias is %g of nominal at t = %e s", k, $abstime);
        @(above(0.1 - abs(k - 1.0)))
            $strobe("predriver_cml: bias valid at t = %e s", $abstime);

        //determine the input polarity
        bit_sign = (V(inp) > V(inn)) ? 1.0 : -1.0;

        //generate non-inv diff outputs
        V(outp) <+ vcm + (vod / 2.0) * k * bit_sign;
        V(outn) <+ vcm - (vod / 2.0) * k * bit_sign;

        $strobe("OUTP = %g V, OUTN = %g V, VDIFF = %g V",
                V(outp), V(outn), V(outp, outn));
    end

endmodule
