// Transmitter clock generator. Structural block, instantiates the clock-tree cells
// and adds no behaviour of its own.
//
// ckin (single-ended CMOS, from tx_pll) -> dcc_cml -> clkbuf_cml (clk14) -> div2_cml
// (clk7) -> cml2cmos -> phase_aligner -> three div2_tspc (3.5, 1.75, 0.875 GHz).
// The phase_aligner aligns clk7 to the data from cml_dff_x4, brought in on pa_data;
// its output drives the TSPC chain.
//
// div2_cml is an ideal placeholder (placeholders/div2_cml.va) until the real one lands.

`ifndef PAM4_TX_CLKGEN_VA
`define PAM4_TX_CLKGEN_VA

`include "disciplines.vams"
`include "dcc_cml.va"
`include "clkbuf_cml.va"
`include "placeholders/div2_cml.va"
`include "cml2cmos.va"
`include "phase_aligner.va"
`include "div2_tspc.va"

module tx_clkgen(ckin, rst, pa_data, clk14_p, clk14_n, clk7_p, clk7_n,
                 clk3p5, clk3p5b, clk1p75, clk0p875, vdd, vss);
  input ckin, rst, pa_data;
  output clk14_p, clk14_n, clk7_p, clk7_n, clk3p5, clk3p5b, clk1p75, clk0p875;
  inout vdd, vss;
  electrical ckin, rst, pa_data, clk14_p, clk14_n, clk7_p, clk7_n;
  electrical clk3p5, clk3p5b, clk1p75, clk0p875, vdd, vss;
  electrical dccp, dccn, c7, c7a, q1p75b, q0p875b;

  (* desc = "dcc_cml input threshold, mid-swing of the CMOS VCO output", units = "V" *)
  parameter real vth_dcc = 0.35;
  (* desc = "scale of the added jitter of the clocking team's cells: 1 = defaults, 0 = none" *)
  parameter real rj_scale = 1 from [0:10];

  dcc_cml #(.vth(vth_dcc)) u_dcc(.clk_in(ckin), .clk_outp(dccp), .clk_outn(dccn), .vss(vss));
  clkbuf_cml #(.rj(40f * rj_scale), .rj_seed(601)) u_buf14(.inp(dccp), .inn(dccn), .outp(clk14_p), .outn(clk14_n), .vdd(vdd), .vss(vss));
  div2_cml u_div7(.inp(clk14_p), .inn(clk14_n), .outp(clk7_p), .outn(clk7_n), .vdd(vdd), .vss(vss));
  cml2cmos u_c2c(.inp(clk7_p), .inn(clk7_n), .out(c7), .vdd(vdd), .vss(vss));
  phase_aligner u_pa(.cml_dff_x4(pa_data), .clk7_cml2cmos(c7), .ck_28(c7a));
  div2_tspc #(.rj(300f * rj_scale), .rj_seed(301)) u_d3p5(.clk(c7a), .rst(rst), .q(clk3p5), .qb(clk3p5b), .vdd(vdd), .vss(vss));
  div2_tspc #(.rj(300f * rj_scale), .rj_seed(302)) u_d1p75(.clk(clk3p5), .rst(rst), .q(clk1p75), .qb(q1p75b), .vdd(vdd), .vss(vss));
  div2_tspc #(.rj(300f * rj_scale), .rj_seed(303)) u_d0p875(.clk(clk1p75), .rst(rst), .q(clk0p875), .qb(q0p875b), .vdd(vdd), .vss(vss));
endmodule

`endif
