`include "constants.vams"
`include "disciplines.vams"

// Ideal behavioral CML-to-CMOS converter.
//
// Function:
//   - Reads a differential CML input: inp and inn.
//   - Determines the logic state from V(inp)-V(inn).
//   - Drives a single-ended CMOS output between VSS and VDD.

module cml2cmos(inp, inn, out, vdd, vss);

    input inp, inn;
    output out;
    inout vdd, vss;

    electrical inp, inn, out, vdd, vss;

    // Differential decision threshold.
    // Positive differential input -> logic 1.
    // Negative differential input -> logic 0.
    parameter real vth_diff = 0.0;

    analog begin
        if (V(inp, inn) > vth_diff) begin
            V(out, vss) <+ V(vdd, vss);
        end
        else begin
            V(out, vss) <+ 0.0;
        end
    end

endmodule
