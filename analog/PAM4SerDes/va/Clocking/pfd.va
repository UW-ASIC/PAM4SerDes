// ref  -> reference clock
// fb   -> feedback clock
// up   -> high while ref is ahead
// dn   -> high while fb is ahead

//! solve
//! print none

`include "constants.vams"
`include "disciplines.vams"

module pfd(ref, fb, up, dn, vdd, gnd);
    input ref, fb, vdd, gnd;
    output up, dn;
    electrical ref, fb, up, dn, vdd, gnd;

    parameter real vth = 0.5;                   // clk threshold for edge
    parameter real td_rst = 50p from [0:inf);   // reset delay (dead zone)
    parameter real t_rf = 0 from [0:inf);       //output rise/fall time

    integer up_q, dn_q; //two flip flop outputs
    real t_reset; // when the pending reset fires

    analog begin
        @(initial_step) begin
            up_q = 0;
            dn_q = 0;
            t_reset = 1e30;     //no reset pending
        end

        //ref rising edge
        @(cross(V(ref) - vth, +1)) begin
            up_q = 1;
            if(dn_q)
                t_reset = $abstime + td_rst; //both high, schedule reset
        end

        @(cross(V(fb) - vth, +1)) begin
            dn_q = 1;
            if(up_q)
                t_reset = $abstime + td_rst; //bot high, schedule reset
        end

        @(timer(t_reset)) begin
            up_q = 0;
            dn_q = 0;
            t_reset = 1e30;
        end

        V(up, gnd) <+ V(vdd, gnd) * transition(up_q, 0, t_rf);
        V(dn, gnd) <+ V(vdd, gnd) * transition(dn_q, 0, t_rf);

        $bound_step(0.01);
    end
endmodule
