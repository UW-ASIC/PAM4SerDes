// Transmitter PLL skeleton. Structural block, wires the loop's cells together
// and adds no behaviour of its own, apart from vctl's start-up hold and C2.
//
// 437.5 MHz x 32 = 14 GHz, type-II loop, zeta = 1, 21.875 MHz bandwidth:
// icp 100 uA, R 25.31 k, C 1.427 p, C2 0.14 p (specs.md, Detailed.png). The team's
// loop_filter_rc is R + C only, so C2 (vctl to vss) is added here.
// Cells: pfd, vco, loop_filter_rc (team), charge_pump (ideal, the circuit was
// scrapped), div_n and lock_detect.
//
// No band[3:0] input: the team's vco has no coarse tuning yet.
// ck is the single-ended CMOS VCO output; ckfb and vctl are monitor outputs.

`ifndef PAM4_TX_PLL_VA
`define PAM4_TX_PLL_VA

`include "disciplines.vams"
`include "pfd.va"
`include "charge_pump.va"
`include "loop_filter_rc.va"
`include "vco.va"
`include "div_n.va"
`include "lock_detect.va"

module tx_pll(ckref, ck, ckfb, lock, vctl, vdd, vss);
  input ckref;
  output ck, ckfb, lock, vctl;
  inout vdd, vss;
  electrical ckref, ck, ckfb, lock, vctl, vdd, vss;
  electrical up, dn;

  (* desc = "feedback division ratio" *)
  parameter integer n = 32 from [2:1023];
  (* desc = "charge pump current", units = "A" *)
  parameter real icp = 100u from (0:inf);
  (* desc = "loop filter resistor", units = "Ohm" *)
  parameter real r = 25.31k from (0:inf);
  (* desc = "loop filter integrating capacitor", units = "F" *)
  parameter real c = 1.427p from (0:inf);
  (* desc = "loop filter shunt capacitor, vctl to vss", units = "F" *)
  parameter real c2 = 0.14p from [0:inf);
  (* desc = "vctl at the start of the transient (DC operating point)", units = "V" *)
  parameter real vc0 = 0.35;
  (* desc = "VCO frequency at vctl = vctl0", units = "Hz" *)
  parameter real f0 = 14G from (0:inf);
  (* desc = "control voltage that gives f0", units = "V" *)
  parameter real vctl0 = 0.35;
  (* desc = "VCO tuning gain", units = "Hz/V" *)
  parameter real kvco = 1.4G from [0:inf);
  (* desc = "PFD input threshold", units = "V" *)
  parameter real vth = 0.35;
  (* desc = "feedback divider's added jitter, rms per edge", units = "s" *)
  parameter real rj_div = 150f from [0:10p];
  (* desc = "seed of the divider's jitter sequence" *)
  parameter integer div_seed = 2;
  (* desc = "good cycles the lock detector needs" *)
  parameter integer n_lock = 256 from [1:inf);

  pfd #(.vth(vth)) u_pfd(.ref(ckref), .fb(ckfb), .up(up), .dn(dn), .vdd(vdd), .gnd(vss));
  charge_pump #(.icp(icp)) u_cp(.up(up), .dn(dn), .en(vdd), .out(vctl), .vdd(vdd), .vss(vss));
  loop_filter_rc #(.R(r), .C(c)) u_lf(.vctrl(vctl), .vss(vss));
  vco #(.f_0(f0), .v_c0(vctl0), .k_vco(kvco)) u_vco(.v_ctrl(vctl), .v_out(ck), .vdd(vdd), .gnd(vss));
  div_n #(.n(n), .rj(rj_div), .rj_seed(div_seed)) u_div(.ckin(ck), .ckout(ckfb), .vdd(vdd), .vss(vss));
  lock_detect #(.n_lock(n_lock)) u_lock(.ckref(ckref), .ckfb(ckfb), .lock(lock), .vdd(vdd), .vss(vss));

  // vctl to vss, ours (the team's loop_filter_rc is R + C only):
  //  - DC operating point: held at vc0, so the filter's capacitor starts charged
  //    there and vctl has a DC path.
  //  - Transient: the loop filter's shunt capacitor C2, which smooths the I*R step
  //    each detector current pulse puts on vctl.
  analog begin
    if (analysis("static"))
      V(vctl, vss) <+ vc0;
    else
      I(vctl, vss) <+ c2 * ddt(V(vctl, vss));
  end
endmodule

`endif
