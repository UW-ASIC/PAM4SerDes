// Ideal glue cells used only inside rx_cdr. They stand for wiring or trivial logic
// that are not represented as blocks, so they add no non-ideal behaviour.
//   diff2se: differential to single-ended, V(out, vss) = V(p, n). cdr_pd_linear
//            reads single-ended signals around 0 V; the AFE data and clk14 are
//            differential.
//   qdelay:  pure delay. cdr_pd_linear needs a quadrature clk14_Q, and Detailed.png
//            has no quadrature source, so rx_cdr delays clk14 by a quarter period.
//   nor2:    smooth ideal NOR, exact at 0 / vdd inputs: y = vdd (1 - a)(1 - b).

`ifndef PAM4_CDR_GLUE_VA
`define PAM4_CDR_GLUE_VA

`include "disciplines.vams"

module diff2se(p, n, out, vss);
  input p, n;
  output out;
  inout vss;
  electrical p, n, out, vss;
  analog
    V(out, vss) <+ V(p, n);
endmodule

module qdelay(in, out, vss);
  input in;
  output out;
  inout vss;
  electrical in, out, vss;
  (* desc = "delay, a quarter of the 14 GHz period by default", units = "s" *)
  parameter real td = 17.857p from (0:1n);
  analog
    V(out, vss) <+ absdelay(V(in, vss), td);
endmodule

module nor2(a, b, y, vdd, vss);
  input a, b;
  output y;
  inout vdd, vss;
  electrical a, b, y, vdd, vss;
  real vs, la, lb;
  analog begin
    vs = V(vdd, vss);
    la = min(max(V(a, vss) / vs, 0.0), 1.0);
    lb = min(max(V(b, vss) / vs, 0.0), 1.0);
    V(y, vss) <+ vs * (1 - la) * (1 - lb);
  end
endmodule

`endif
