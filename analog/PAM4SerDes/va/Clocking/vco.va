`ifndef PAM4_VCO_VA
`define PAM4_VCO_VA

// Voltage Controlled Oscillator (VCO)
// mathematically:  f_osc = f(V_ctrl)
// typically:       f_osc = f_0 + K_VCO * V_ctrl
//    f_0   -> center frequency
//    K_VCO -> gain of the VCO (Hz/V)
//
// phase = [idt(f_osc) + p_init] mod 2*pi

//! solve
//! print none

`include "constants.vams"
`include "disciplines.vams"

module vco(v_ctrl, v_out, vdd, gnd);
    input v_ctrl;
    output v_out;
    inout vdd, gnd;
    electrical v_ctrl, v_out, vdd, gnd;

    parameter real f_0      = 5e9 from (0:inf); // center frequency
    parameter real v_c0     = 0;                // V_ctrl that gives f_0
    parameter real k_vco    = 2e9;              // gain
    parameter real p_init   = 0;                // initial phase
    parameter real v_amp    = 0.7 from (0:inf); // output high level above gnd (CMOS 0.7 V)
    parameter real t_rf     = 2p from (0:inf);  // output rise/fall time; 0 stalls ngspice

    real frequency, phase;
    integer high;

    analog begin
        frequency = f_0 + k_vco * (V(v_ctrl, gnd) - v_c0);

        //Angular frequency to phase formula, in Razavi page 646
        phase = 2 * `M_PI * idtmod(frequency, p_init/(2 * `M_PI), 1);

        @(initial_step)
            high = 0;

        @(cross($sin(phase), +1))
            high = 1;

        @(cross($sin(phase), -1))
            high = 0;

        V(v_out, gnd) <+ v_amp * transition(high, 0, t_rf);

        $bound_step(0.1/frequency);
    end
endmodule

`endif
