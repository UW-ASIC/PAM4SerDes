// demux2_cmos - 1:2 demultiplexer, CMOS levels.
//
// Signals are single-ended and rail to rail (0 .. vdd).
// The clock runs at half the input bit rate (1.75 GHz for 3.5 Gb/s in).
// - rising edge : capture d into a holding stage (earlier bit)
// - falling edge: q1 <= d, q0 <= held bit (later bit, and release)
// Both outputs change together on the falling edge and each bit lasts two input bit periods.
// q0 carries the earlier bit of every pair.
//
// Structure (the classic 5-latch 1:2 demux):
// - ma to sa    rising-edge flip-flop on d (ma transparent clk low,  sa clk high)
// - sa to ra    re-time to the falling edge (ra transparent clk low)  to q0
// - mb to sb    falling-edge flip-flop on d (mb transparent clk high, sb clk low) to q1

`ifndef DEMUX2_CMOS_VA
`define DEMUX2_CMOS_VA
`include "disciplines.vams"

// x tracks tgt while s = 1, holds and regenerates while s = 0.
`define LATCH(x, s, tgt, off) \
    I(x) <+ ddt(tau * V(x)) + (s) * (V(x) - (tgt)) \
          + (1.0 - (s)) * (V(x) - tanh((V(x) - (off)) / eps_hold));

module demux2_cmos(d, clk, q0, q1);
    input d, clk;
    output q0, q1;
    electrical d, clk, q0, q1;
    electrical ma, sa, ra, mb, sb;

    parameter real vdd = 0.7 from (0:inf);
    parameter real v_th_d = vdd / 2.0;     // data threshold
    parameter real v_th_clk = vdd / 2.0;   // clock threshold
    parameter real tau = 0.1e-12 from (0:inf);      // latch time constant
    parameter real eps_in = 1.0e-3 from (0:inf);    // comparator softness [V]
    parameter real eps_clk = 1.0e-3 from (0:inf);
    parameter real eps_hold = 0.05 from (0:inf);
    parameter integer init_q0 = 0 from [0:1];
    parameter integer init_q1 = 0 from [0:1];

    real din, hi, lo, off0, off1;

    analog begin
        // Bias each holding latch's DC solution toward its initial value.
        off0 = 0.5 - init_q0;
        off1 = 0.5 - init_q1;

        din = tanh((V(d) - v_th_d) / eps_in);
        hi = 0.5 * (1.0 + tanh((V(clk) - v_th_clk) / eps_clk));
        lo = 1.0 - hi;

        `LATCH(ma, lo, din, off0)
        `LATCH(sa, hi, V(ma), off0)
        `LATCH(ra, lo, V(sa), off0)
        `LATCH(mb, hi, din, off1)
        `LATCH(sb, lo, V(mb), off1)

        V(q0) <+ 0.5 * vdd * (1.0 + V(ra));
        V(q1) <+ 0.5 * vdd * (1.0 + V(sb));
    end
endmodule
`endif
