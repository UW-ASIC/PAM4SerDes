`include "disciplines.vams"
`include "demux2_cml.va"
`include "demux2_cmos.va"

// Module's purpose: Serial to parallel converter
module rx_deser_path(
    d0_p, d0_n,
    d1_p, d1_n,
    clk7_p, clk7_n,
    clk3p5_p, clk3p5_n,
    clk1p75, clk875, word_clk,
    data_out
);

    input d0_p, d0_n, d1_p, d1_n;
    input clk7_p, clk7_n;
    input clk3p5_p, clk3p5_n;
    input clk1p75, clk875, word_clk;

    output [0:31] data_out;

    electrical d0_p, d0_n, d1_p, d1_n;
    electrical clk7_p, clk7_n;
    electrical clk3p5_p, clk3p5_n;
    electrical clk1p75, clk875, word_clk;

    electrical [0:31] data_out;

    // Stage 1: 4 differential lanes
    electrical [0:3] s1_p, s1_n;

    // Stage 2: 8 differential lanes
    electrical [0:7] s2_p, s2_n;

    // CML-to-CMOS conversion
    electrical [0:7] cmos_in;

    // Stage 3: 16 single-ended lanes
    electrical [0:15] s3;

    // Stage 4: 32 single-ended lanes
    electrical [0:31] s4;

    parameter real vdd_cmos = 0.7 from (0:inf);

    integer output_state[0:31];
    integer k;
    genvar g;

    // Stage 1 demux instances
    // Phase 0 input
    demux2_cml dmx1_0(
        d0_p, d0_n,
        clk7_p, clk7_n,
        s1_p[0], s1_n[0],
        s1_p[2], s1_n[2]
    );

    // Phase 1 input
    demux2_cml dmx1_1(
        d1_p, d1_n,
        clk7_p, clk7_n,
        s1_p[1], s1_n[1],
        s1_p[3], s1_n[3]
    );
    // Stage 2 demux instances
    demux2_cml dmx2_0(
        s1_p[0], s1_n[0],
        clk3p5_p, clk3p5_n,
        s2_p[0], s2_n[0],
        s2_p[4], s2_n[4]
    );

    demux2_cml dmx2_1(
        s1_p[1], s1_n[1],
        clk3p5_p, clk3p5_n,
        s2_p[1], s2_n[1],
        s2_p[5], s2_n[5]
    );

    demux2_cml dmx2_2(
        s1_p[2], s1_n[2],
        clk3p5_p, clk3p5_n,
        s2_p[2], s2_n[2],
        s2_p[6], s2_n[6]
    );

    demux2_cml dmx2_3(
        s1_p[3], s1_n[3],
        clk3p5_p, clk3p5_n,
        s2_p[3], s2_n[3],
        s2_p[7], s2_n[7]
    );

    // Stage 3 demux instances
    demux2_cmos dmx3_0(cmos_in[0], clk1p75, s3[0], s3[8]);
    demux2_cmos dmx3_1(cmos_in[1], clk1p75, s3[1], s3[9]);
    demux2_cmos dmx3_2(cmos_in[2], clk1p75, s3[2], s3[10]);
    demux2_cmos dmx3_3(cmos_in[3], clk1p75, s3[3], s3[11]);
    demux2_cmos dmx3_4(cmos_in[4], clk1p75, s3[4], s3[12]);
    demux2_cmos dmx3_5(cmos_in[5], clk1p75, s3[5], s3[13]);
    demux2_cmos dmx3_6(cmos_in[6], clk1p75, s3[6], s3[14]);
    demux2_cmos dmx3_7(cmos_in[7], clk1p75, s3[7], s3[15]);
    // Stage 4 demux instances
    demux2_cmos dmx4_0(s3[0], clk875, s4[0], s4[16]);
    demux2_cmos dmx4_1(s3[1], clk875, s4[1], s4[17]);
    demux2_cmos dmx4_2(s3[2], clk875, s4[2], s4[18]);
    demux2_cmos dmx4_3(s3[3], clk875, s4[3], s4[19]);
    demux2_cmos dmx4_4(s3[4], clk875, s4[4], s4[20]);
    demux2_cmos dmx4_5(s3[5], clk875, s4[5], s4[21]);
    demux2_cmos dmx4_6(s3[6], clk875, s4[6], s4[22]);
    demux2_cmos dmx4_7(s3[7], clk875, s4[7], s4[23]);
    demux2_cmos dmx4_8(s3[8], clk875, s4[8], s4[24]);
    demux2_cmos dmx4_9(s3[9], clk875, s4[9], s4[25]);
    demux2_cmos dmx4_10(s3[10], clk875, s4[10], s4[26]);
    demux2_cmos dmx4_11(s3[11], clk875, s4[11], s4[27]);
    demux2_cmos dmx4_12(s3[12], clk875, s4[12], s4[28]);
    demux2_cmos dmx4_13(s3[13], clk875, s4[13], s4[29]);
    demux2_cmos dmx4_14(s3[14], clk875, s4[14], s4[30]);
    demux2_cmos dmx4_15(s3[15], clk875, s4[15], s4[31]);
    // Voltage conversion and output register
    integer stage4_bits[0:31];
    genvar j;
    genvar m;
    analog begin

    @(initial_step) begin
        for (k = 0; k < 32; k = k + 1)
            output_state[k] = 0;
    end

    // CML-to-CMOS conversion
    for (g = 0; g < 8; g = g + 1) begin
        V(cmos_in[g]) <+
            (V(s2_p[g], s2_n[g]) > 0)
            ? vdd_cmos : 0.0;
    end

    // Read final demux outputs
    for (j = 0; j < 32; j = j + 1) begin
        stage4_bits[j] = V(s4[j]) > vdd_cmos / 2.0;
    end

    // Final parallel output register
    @(cross(V(word_clk) - vdd_cmos / 2.0, +1)) begin
        for (k = 0; k < 32; k = k + 1)
            output_state[k] = stage4_bits[k];
    end

    // Drive registered outputs
    for (m = 0; m < 32; m = m + 1) begin
        V(data_out[m]) <+ output_state[m] * vdd_cmos;
    end

end
endmodule
