// this the big boy
// test cases (copy pasted from slicer.va)

//! time 0, 17.86e-12, 35.71e-12, 53.57e-12, 71.43e-12, 89.29e-12, 107.14e-12, 125e-12, 142.86e-12, 160.71e-12, 178.57e-12, 196.43e-12, 214.29e-12, 232.14e-12, 250e-12, 267.86e-12
//! wave V(clkp) = -0.2, 0.2, 0.2, -0.2, -0.2, 0.2, 0.2, -0.2, -0.2, 0.2, 0.2, -0.2, -0.2, 0.2, 0.2, -0.2
//! wave V(vinp) = 0.15, 0.15, -0.05, -0.05, -0.05, -0.05, 0.05, 0.05, 0.05, 0.05, -0.15, -0.15, -0.15, -0.15, -0.15, -0.15
//! bias V(vinn) = 0, V(clkn) = 0
// V(vth_topp) = 0.1, V(vth_topn) = 0, V(vth_midp)=0, V(vth_midn) = 0, V(vth_botp)= -0.1, V(vth_botn)=0
//! solve
//! print none

`include "disciplines.vams"
`include "slicer.va"
`include "threshold_dac.va"

module pam4_slicer(vinp, vinn, voutp1, voutn1, voutp2, voutn2, voutp3, voutn3,
clkp, clkn);

    input vinp, vinn, clkp, clkn;
    output voutp1, voutn1, voutp2, voutn2, voutp3, voutn3;
    electrical vinp, vinn, clkp, clkn, vth_topp, vth_topn, vth_midp, vth_midn, vth_botp, vth_botn,
    voutp1, voutn1, voutp2, voutn2, voutp3, voutn3;

    //to calculate the code, know that vthreshold = vmin + code*step, where vmin is -166.6mV. the three vthreshold are +-100mV and 0mv
    parameter integer code_top = 51 from [0:63];
    parameter integer code_mid = 32 from [0:63];
    parameter integer code_bot = 13 from [0:63];

    threshold_dac #(.code(code_top)) th_top(vth_topp, vth_topn);
    threshold_dac #(.code(code_mid)) th_mid(vth_midp, vth_midn);
    threshold_dac #(.code(code_bot)) th_bot(vth_botp, vth_botn);

    slicer top(vinp, vinn, voutp1, voutn1, clkp, clkn, vth_topp, vth_topn);
    slicer mid(vinp, vinn, voutp2, voutn2, clkp, clkn, vth_midp, vth_midn);
    slicer bot(vinp, vinn, voutp3, voutn3, clkp, clkn, vth_botp, vth_botn);

    analog begin
        @(cross(V(clkp,clkn), -1)) begin
            // prints it bot mid top, so abc?
            $strobe ("Thermometer Code: %0d%0d%0d", V(voutp3,voutn3)>0, V(voutp2,voutn2)>0, V(voutp1, voutn1)>0);
        end
    end
endmodule
