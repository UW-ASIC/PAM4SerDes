// lesgooooo. cml slicer so we need a differential pair for everything
// levels for the pam4 are -150, -50, 50, 150 mV
// this means that the thresholds are -100,0,100mV
// def shifts are +- 12.82 and +=4.27 mV
// 2 phases at 14 GHz
// 24 slicers
// offset <= 5mV
// output should be 000, 001, 011, 111 thermometer code
// noise budget is 3.367mV rms

//test cases generated by claude. voltage is +-150mV and +-50mV, time is 14GHz
//! time 0, 17.86e-12, 35.71e-12, 53.57e-12, 71.43e-12, 89.29e-12, 107.14e-12, 125e-12, 142.86e-12, 160.71e-12, 178.57e-12, 196.43e-12, 214.29e-12, 232.14e-12, 250e-12, 267.86e-12
//! wave V(clkp) = -0.2, 0.2, 0.2, -0.2, -0.2, 0.2, 0.2, -0.2, -0.2, 0.2, 0.2, -0.2, -0.2, 0.2, 0.2, -0.2
//! wave V(vinp) = 0.15, 0.15, -0.05, -0.05, -0.05, -0.05, 0.05, 0.05, 0.05, 0.05, -0.15, -0.15, -0.15, -0.15, -0.15, -0.15
//! bias V(vinn) = 0, V(vthp) = 0, V(vthn) = 0, V(clkn) = 0
//! solve
//! print none
`include "disciplines.vams"

module slicer(vinp, vinn, voutp, voutn, clkp, clkn, vthp, vthn);
    input vinp, vinn, clkp, clkn, vthp, vthn;
    output voutp, voutn;
    electrical vinp, vinn, clkp, clkn, vthp, vthn, voutp, voutn;

    // these variables have a placeholder bc i have no idea what im doing
    parameter real offset = 0 from [-0.005:0.005]; //worst case of 5mV
    parameter real t_risefall = 5p from (0:inf);
    parameter real t_delay = 0 from [0:inf);
    //cm is midpoint
    parameter real v_commonmode = 0.5 from [0:0.7];
    // vswing is basically peak to peak voltage
    parameter real vswing = 300m from (0:inf);

    integer hold;
    // i think i can set hold above, or below, or through @initial_step.
    analog initial begin
        hold = -1;
    end

    analog begin
        @(cross(V(clkp, clkn), +1)) begin
            hold = (V(vinp, vinn) > V(vthp,vthn) + offset) ? +1 : -1;
            //commented out the strobe print because i'm printing in pam4_slicer.va
            // $strobe("vin = %gmV hold = %g", 1000*V(vinp, vinn), hold);
        end
        V(voutp) <+ v_commonmode + vswing*0.5*transition(hold, t_delay, t_risefall, t_risefall);
        V(voutn) <+ v_commonmode - vswing*0.5*transition(hold, t_delay, t_risefall, t_risefall);
        // $strobe("Voutp = %g V, Voutn = %g V", V(voutp), V(voutn));
    end
endmodule
