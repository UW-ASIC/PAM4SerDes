`include "disciplines.vams"

module rx_dec_retime(
    msb_in, lsb_in,
    clk_p, clk_n,
    msb_out_p, msb_out_n,
    lsb_out_p, lsb_out_n
);

    input msb_in, lsb_in;
    input clk_p, clk_n;

    output msb_out_p, msb_out_n;
    output lsb_out_p, lsb_out_n;

    electrical msb_in, lsb_in;
    electrical clk_p, clk_n;
    electrical msb_out_p, msb_out_n;
    electrical lsb_out_p, lsb_out_n;

    parameter real vth_data = 0.9;
    parameter real vdd = 1.0 from (0:inf);
    parameter real v_swing = 0.300 from (0:inf);
    parameter real v_cm = vdd - v_swing / 2.0;

    integer msb_state;
    integer lsb_state;

    analog begin

        @(initial_step) begin
            msb_state = 0;
            lsb_state = 0;
        end

        @(cross(V(clk_p, clk_n), +1)) begin
            msb_state = (V(msb_in) > vth_data);
            lsb_state = (V(lsb_in) > vth_data);
        end

        V(msb_out_p) <+ v_cm + v_swing * (msb_state - 0.5);
        V(msb_out_n) <+ v_cm - v_swing * (msb_state - 0.5);

        V(lsb_out_p) <+ v_cm + v_swing * (lsb_state - 0.5);
        V(lsb_out_n) <+ v_cm - v_swing * (lsb_state - 0.5);

    end

endmodule
