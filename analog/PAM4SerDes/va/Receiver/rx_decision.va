`ifndef PAM4_RX_DECISION_VA
`define PAM4_RX_DECISION_VA

`include "disciplines.vams"
`include "Slicer/slicer.va"
`include "dfe1_unrolled_hr.va"
`include "pam4_dec.va"

// Module's purpose: 24 slicers + 1-tap unrolled DFE + one PAM4 decoder per phase.
// Slicer g = 12 * phase + 3 * hypothesis + threshold (dfe1_unrolled_hr's numbering):
// phase 0 samples on the rising edge of clk, phase 1 on the falling edge (its clock
// is connected swapped). The DFE drives every slicer's reference.
//
// The decoders read single-ended logic and the DFE's thermometer outputs are
// differential, so each decoder takes the positive leg and compares it with the
// DFE's output common mode, vdd - 0.15 V. The negative legs are left unconnected.
module rx_decision(
    vinp, vinn,
    clk_p, clk_n,
    msb0, lsb0,
    msb1, lsb1
);

    input vinp, vinn, clk_p, clk_n;
    output msb0, lsb0, msb1, lsb1;

    electrical vinp, vinn;
    electrical clk_p, clk_n;
    electrical msb0, lsb0, msb1, lsb1;

    electrical [0:23] cand_p, cand_n;
    electrical [0:23] ref_p, ref_n;
    electrical [0:5] therm_p, therm_n;

    parameter real vdd = 0.7 from (0:inf);          // supply the CML and logic levels follow
    parameter real alpha = 0.08548;                 // DFE tap: first post-cursor / main cursor
    parameter real v_level = 50.0e-3 from (0:inf);  // PAM4 levels {-3,-1,+1,+3} * v_level at the slicers
    parameter real v_thr = 100.0e-3 from (0:inf);   // slicer thresholds {-1,0,+1} * v_thr

    // Instantiate DFE
    dfe1_unrolled_hr #(.vdd(vdd), .alpha(alpha), .v_level(v_level), .v_thr(v_thr)) dfe(
    clk_p, clk_n,
    cand_p, cand_n,
    ref_p, ref_n,
    therm_p, therm_n
);
    // Instantiate phase 0 slicers
    slicer s0(vinp, vinn, cand_p[0], cand_n[0], clk_p, clk_n, ref_p[0], ref_n[0]);
    slicer s1(vinp, vinn, cand_p[1], cand_n[1], clk_p, clk_n, ref_p[1], ref_n[1]);
    slicer s2(vinp, vinn, cand_p[2], cand_n[2], clk_p, clk_n, ref_p[2], ref_n[2]);
    slicer s3(vinp, vinn, cand_p[3], cand_n[3], clk_p, clk_n, ref_p[3], ref_n[3]);
    slicer s4(vinp, vinn, cand_p[4], cand_n[4], clk_p, clk_n, ref_p[4], ref_n[4]);
    slicer s5(vinp, vinn, cand_p[5], cand_n[5], clk_p, clk_n, ref_p[5], ref_n[5]);
    slicer s6(vinp, vinn, cand_p[6], cand_n[6], clk_p, clk_n, ref_p[6], ref_n[6]);
    slicer s7(vinp, vinn, cand_p[7], cand_n[7], clk_p, clk_n, ref_p[7], ref_n[7]);
    slicer s8(vinp, vinn, cand_p[8], cand_n[8], clk_p, clk_n, ref_p[8], ref_n[8]);
    slicer s9(vinp, vinn, cand_p[9], cand_n[9], clk_p, clk_n, ref_p[9], ref_n[9]);
    slicer s10(vinp, vinn, cand_p[10], cand_n[10], clk_p, clk_n, ref_p[10], ref_n[10]);
    slicer s11(vinp, vinn, cand_p[11], cand_n[11], clk_p, clk_n, ref_p[11], ref_n[11]);

    // Instantiate phase 1 slicers
    slicer s12(vinp, vinn, cand_p[12], cand_n[12], clk_n, clk_p, ref_p[12], ref_n[12]);
    slicer s13(vinp, vinn, cand_p[13], cand_n[13], clk_n, clk_p, ref_p[13], ref_n[13]);
    slicer s14(vinp, vinn, cand_p[14], cand_n[14], clk_n, clk_p, ref_p[14], ref_n[14]);
    slicer s15(vinp, vinn, cand_p[15], cand_n[15], clk_n, clk_p, ref_p[15], ref_n[15]);
    slicer s16(vinp, vinn, cand_p[16], cand_n[16], clk_n, clk_p, ref_p[16], ref_n[16]);
    slicer s17(vinp, vinn, cand_p[17], cand_n[17], clk_n, clk_p, ref_p[17], ref_n[17]);
    slicer s18(vinp, vinn, cand_p[18], cand_n[18], clk_n, clk_p, ref_p[18], ref_n[18]);
    slicer s19(vinp, vinn, cand_p[19], cand_n[19], clk_n, clk_p, ref_p[19], ref_n[19]);
    slicer s20(vinp, vinn, cand_p[20], cand_n[20], clk_n, clk_p, ref_p[20], ref_n[20]);
    slicer s21(vinp, vinn, cand_p[21], cand_n[21], clk_n, clk_p, ref_p[21], ref_n[21]);
    slicer s22(vinp, vinn, cand_p[22], cand_n[22], clk_n, clk_p, ref_p[22], ref_n[22]);
    slicer s23(vinp, vinn, cand_p[23], cand_n[23], clk_n, clk_p, ref_p[23], ref_n[23]);

    // Instantiate PAM4 decoders, one per phase
    pam4_dec #(.vhigh(vdd), .vth(vdd - 0.15)) dec0(
    therm_p[0],
    therm_p[1],
    therm_p[2],
    msb0,
    lsb0
);
    pam4_dec #(.vhigh(vdd), .vth(vdd - 0.15)) dec1(
    therm_p[3],
    therm_p[4],
    therm_p[5],
    msb1,
    lsb1
);

endmodule

`endif
