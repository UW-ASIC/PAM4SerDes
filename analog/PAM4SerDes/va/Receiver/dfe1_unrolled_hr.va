// dfe1_unrolled_hr - 1-tap unrolled decision feedback equalizer, half rate.
//
// Received signal: r[n] = x[n] + alpha * x[n-1]. The slicers compare r[n] against
// thresholds pre-shifted for every possible previous level; this block
// 1. drives the 24 slicer references  ref[g] = T_k + alpha * L_h
//    T_k = {-1, 0, +1} * v_thr,  L_h = {-3, -1, +1, +3} * v_level
// 2. per phase, picks the 3 candidates whose hypothesis h equals the level the other phase decided one UI earlier.
//
// Slicer interface:
// - g = 12 * phase + 3 * h + k              (ref and cand buses)
// - cand[g] > 0 (differential) when the input is above ref[g]
// - phase 0 samples on the rising clock edge, phase 1 on the falling edge, and candidates hold until that phase's next sample
// Output: therm[3 * phase + k], thermometer code at -v_thr, 0, +v_thr.
//
// Phase 0 resolves on the falling edge (reading phase 1's level), phase 1 on the
// rising edge (reading phase 0's level), so each reads a value that is not changing.

`ifndef DFE1_UNROLLED_HR_VA
`define DFE1_UNROLLED_HR_VA
`include "disciplines.vams"

module dfe1_unrolled_hr(clk_p, clk_n, cand_p, cand_n, ref_p, ref_n, therm_p, therm_n);
    input clk_p, clk_n;
    input [0:23] cand_p, cand_n;
    output [0:23] ref_p, ref_n;
    output [0:5] therm_p, therm_n;
    electrical clk_p, clk_n;
    electrical [0:23] cand_p, cand_n, ref_p, ref_n;
    electrical [0:5] therm_p, therm_n;

    parameter real vdd = 1.0 from (0:inf);
    parameter real v_swing = 0.300 from (0:inf);
    parameter real v_cm = vdd - v_swing / 2.0;
    parameter real alpha = 0.08548; // first post-cursor / main cursor
    parameter real v_level = 50.0e-3 from (0:inf); // levels {-3,-1,+1,+3} * v_level
    parameter real v_thr = 100.0e-3 from (0:inf); // thresholds {-1,0,+1} * v_thr
    parameter real tt = 10.0e-12 from (0:inf); // output rise/fall time
    parameter integer init_level = 0 from [0:3]; // level assumed before the first symbol

    real c[0:23]; // candidate differentials
    integer t[0:5]; // thermometer bits, 3 * phase + k
    integer lvl0, lvl1; // decided level of each phase, 0 .. 3
    integer k;
    real r;
    genvar g;

    analog begin
        @(initial_step) begin
            for (k = 0; k < 6; k = k + 1)
                t[k] = init_level > k % 3;
            lvl0 = init_level;
            lvl1 = init_level;
        end

        for (g = 0; g < 24; g = g + 1) begin
            r = (g % 3 - 1) * v_thr + alpha * (2 * ((g / 3) % 4) - 3) * v_level;
            V(ref_p[g]) <+ v_cm + 0.5 * r;
            V(ref_n[g]) <+ v_cm - 0.5 * r;
            c[g] = V(cand_p[g], cand_n[g]);
        end

        // Phase 0: candidates 0..11, hypothesis = phase 1's level.
        @(cross(V(clk_p, clk_n), -1)) begin
            lvl0 = 0;
            for (k = 0; k < 3; k = k + 1) begin
                t[k] = c[3 * lvl1 + k] > 0;
                lvl0 = lvl0 + t[k];
            end
        end

        // Phase 1: candidates 12..23, hypothesis = phase 0's level.
        @(cross(V(clk_p, clk_n), +1)) begin
            lvl1 = 0;
            for (k = 0; k < 3; k = k + 1) begin
                t[3 + k] = c[12 + 3 * lvl0 + k] > 0;
                lvl1 = lvl1 + t[3 + k];
            end
        end

        // Each leg swings v_cm +- v_swing / 2.
        for (g = 0; g < 6; g = g + 1) begin
            V(therm_p[g]) <+ v_cm + v_swing * (transition(t[g], 0, tt) - 0.5);
            V(therm_n[g]) <+ v_cm - v_swing * (transition(t[g], 0, tt) - 0.5);
        end
    end
endmodule
`endif
