// demux2_cml - 1:2 demultiplexer, current mode logic levels.
//
// Signals are differential around v_cm = vdd - v_swing / 2.
// The clock runs at half the input bit rate (7 GHz for 14 Gb/s in).
// - rising edge : capture d into a holding stage (earlier bit)
// - falling edge: q1 <= d, q0 <= held bit (later bit, and release)
// Both outputs change together on the falling edge and each bit lasts two input bit
// periods. q0 carries the earlier bit of every pair.
//
// Structure (the classic 5-latch 1:2 demux):
// - ma to sa: rising-edge flip-flop on d (ma transparent clk low, sa clk high)
// - sa to ra: re-time to the falling edge (ra transparent clk low) to q0
// - mb to sb: falling-edge flip-flop on d (mb transparent clk high, sb clk low) to q1

`ifndef DEMUX2_CML_VA
`define DEMUX2_CML_VA
`include "disciplines.vams"

// x tracks tgt while s = 1, holds and regenerates while s = 0.
`define LATCH(x, s, tgt, off) \
    I(x) <+ ddt(tau * V(x)) + (s) * (V(x) - (tgt)) \
          + (1.0 - (s)) * (V(x) - tanh((V(x) - (off)) / eps_hold));

module demux2_cml(d_p, d_n, clk_p, clk_n, q0_p, q0_n, q1_p, q1_n);
    input d_p, d_n, clk_p, clk_n;
    output q0_p, q0_n, q1_p, q1_n;
    electrical d_p, d_n, clk_p, clk_n, q0_p, q0_n, q1_p, q1_n;
    electrical ma, sa, ra, mb, sb;

    parameter real vdd = 1.0 from (0:inf);
    parameter real v_swing = 0.300 from (0:inf);
    parameter real v_cm = vdd - v_swing / 2.0;
    parameter real tau = 0.1e-12 from (0:inf); // latch time constant
    parameter real eps_in = 1.0e-3 from (0:inf);    // comparator softness [V]
    parameter real eps_clk = 1.0e-3 from (0:inf);
    parameter real eps_hold = 0.05 from (0:inf);
    parameter integer init_q0 = 0 from [0:1];
    parameter integer init_q1 = 0 from [0:1];

    real din, hi, lo, off0, off1;

    analog begin
        // Bias each holding latch's DC solution toward its initial value.
        off0 = 0.5 - init_q0;
        off1 = 0.5 - init_q1;

        din = tanh(V(d_p, d_n) / eps_in);
        hi = 0.5 * (1.0 + tanh(V(clk_p, clk_n) / eps_clk));
        lo = 1.0 - hi;

        `LATCH(ma, lo, din, off0)
        `LATCH(sa, hi, V(ma), off0)
        `LATCH(ra, lo, V(sa), off0)
        `LATCH(mb, hi, din, off1)
        `LATCH(sb, lo, V(mb), off1)

        // Each leg swings v_cm +- v_swing / 2, so the differential swing is +-v_swing.
        V(q0_p) <+ v_cm + 0.5 * v_swing * V(ra);
        V(q0_n) <+ v_cm - 0.5 * v_swing * V(ra);
        V(q1_p) <+ v_cm + 0.5 * v_swing * V(sb);
        V(q1_n) <+ v_cm - 0.5 * v_swing * V(sb);
    end
endmodule
`endif
